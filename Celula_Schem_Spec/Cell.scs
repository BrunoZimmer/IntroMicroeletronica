*OR

simulator lang=spice
.param cap=0.2f
.param slew=41p

.include 'OR2.spi'
.include 'INV.spi'
.include 'NAND2.spi'

Vd vsupply 0 1
Va in 0 1 PWL 0 0 1n 0 '(slew*(10/8)+1n)' 1 3n 1 4n 1 '(slew*(10/8)+4n)' 0
Vc c 0 1

X1 in 0 out1 vsupply 0 OR
X2 out1 c out2 vsupply 0 NAND
X3 out2 out vsupply 0 INV
Cload out 0 'cap'

.TRAN 100p 10n

.option rawfmt="psfbin"
